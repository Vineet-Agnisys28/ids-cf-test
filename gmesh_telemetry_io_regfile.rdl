
`include "gmesh_telemetry_agent_regfile.rdl"
`ifndef _GMESH_TELEMETRY_IO_REGFILE_
`define _GMESH_TELEMETRY_IO_REGFILE_
regfile gmesh_telemetry_io_regfile #(
  longint unsigned INTERVAL_WINDOW_CNT_WIDTH  = 16,
  longint unsigned NUM_TELEMETRY_COUNTERS     = 8,
  longint unsigned ADDR_WIDTH                 = 48,
  longint unsigned AGENT_ID_WIDTH             = 9
)
  {
  name = "gmesh_telemetry_io_regfile";
  desc = "Telemetry IO agent FW interface";
  default sw = rw;
  default hw = r;

  gmesh_telemetry_agent_regfile #(
    .INTERVAL_WINDOW_CNT_WIDTH (INTERVAL_WINDOW_CNT_WIDTH),
    .NUM_TELEMETRY_COUNTERS    (NUM_TELEMETRY_COUNTERS   ),
    .ADDR_WIDTH                (ADDR_WIDTH               ),
    .AGENT_ID_WIDTH            (AGENT_ID_WIDTH           ),
    .HAS_COUNTER_FILTER        (1'b1                     ),
    .HAS_RATIO_CALCULATION     (1'b1                     ),
    .HAS_APB_INTERFACE         (1'b0                     ),
    .HAS_ATTRIBUTE_FILTERING   (1'b0                     ))
  gmesh_telemetry_io_agent;
  reg event_mapping_reg {
    desc = "FW maps events to specific counters in the packet. Only 4 events active!";
    default sw = rw;
    default hw = r;
    field {
      desc = "mapping of event i - last 4 event map zero's";
    } value[2:0] = 0;
  };

  event_mapping_reg  event_mapping[NUM_TELEMETRY_COUNTERS];

  reg {
    default sw = rw;
    default hw = r;
    field {
      desc = "FW configured io telemetry accumulation window";
    } window[1*INTERVAL_WINDOW_CNT_WIDTH-1:0*INTERVAL_WINDOW_CNT_WIDTH] = 0;
    field {
      desc = "FW configured io telemetry accumulation window offset";
    } window_offset[2*INTERVAL_WINDOW_CNT_WIDTH-1:1*INTERVAL_WINDOW_CNT_WIDTH] = 0;
  } accumulation;
};

`endif
