`ifndef _MIPA_US_HASH_REGFILE_
`define _MIPA_US_HASH_REGFILE_


regfile mipa_us_hash_regfile #(
  bit HAS_ACELITEDVM                                = 1,
  // Up to 32
  longint unsigned NUM_ACELITE                      = 1,
  longint unsigned NUM_ACELITE_FIXED                = (NUM_ACELITE > 0)? NUM_ACELITE : 1, // DO NOT OVERRIDE
  // 2**LOG2_NUM_QUEUES must be greater or equal to NUM_PORTS
  longint unsigned LOG2_NUM_QUEUES                  = 4,
  longint unsigned HASH_MASK_REDUCED_WIDTH          = 11,
  longint unsigned AXID_WIDTH       = 9
)
{
  name = "mipa_us_hash_regfile";
  desc = "MI-A/P Reorder Hash Register File shared among all AceLite(DVM) ports MI-A/P.
          Used to reorder responses. The configuration registers distribute the AXI ports to different queues
          according to port index and axid accrding to hash function.
          ";

  default sw = rw;
  default hw = r;

  reg cfg_hash_mask {
    field {
      desc = "Hash output mask for single port and a single bit output.
              This reduces #bits(axid) to #bits(TOTAL_NUM_QUEUES)
              responses towards the AXI can bypass each other (if have different AXID).
              out_queue_overflow[i] =  ^(hash_masks[i] & axid).
              NOTE: it is possible that in some scenarios different axid will have the same queue id.
              That may cause performance degragation.
              In general it is preferred that the mask will look at the intresting bits.
              Example: let's say that axid may be 2'b00, 2'b01, 2'b10, 2'b11 and we have 8 queues. Each of the following configurations is optimal:
              1. hash_masks[1] = 2'b10, hash_masks[0] = 2'b01, hash_masks[2] = 2'b00;
                 The following settings would choose queues 0, 1, 2, 3 for AXID 0,1,2,3.
              2. hash_masks[2] = 2'b10, hash_masks[1] = 2'b01, hash_masks[0] = 2'b00
                 The following settings would choose queues 0, 2, 4, 6 for AXID 0,1,2,3.
              3. hash_masks[0] = 2'b10, hash_masks[1] = 2'b01, hash_masks[2] = 2'b00
                 The following settings would choose queues 0, 2, 1, 3 for AXID 0,1,2,3
              In many cases we may have more AXID than queues and they are uniformly selected,
              then any function that uniformly distribute the AXID is good. For example:
                hash_masks[i][j] = 1 iff j = i + AXID_WIDTH/LOG2_NUM_QUEUES.
                Numerical example:
                  AXID = 0..15 (AXID_WIDTH=4)
                  NUM_QUEUES = 4 (LOG2_NUM_QUEUES=2)
                  hash_masks[0] = 4'b1010
                  hash_masks[1] = 4'b0101
                  out_queue_overflow = 0 iff AXID = 0, 5, 12, 15
                  out_queue_overflow = 1 iff AXID = 2, 7, 8 , 13
                  out_queue_overflow = 2 iff AXID = 1, 4, 11, 14
                  out_queue_overflow = 3 iff AXID = 3, 6, 9 , 12
              ";
    } value [AXID_WIDTH-1:0] = 0;
  };
  cfg_hash_mask cfg_acelite_mask[HASH_MASK_REDUCED_WIDTH][NUM_ACELITE_FIXED];
  cfg_hash_mask cfg_acelitedvm_mask[HASH_MASK_REDUCED_WIDTH];

  cfg_acelite_mask->ispresent    = (NUM_ACELITE>0);
  cfg_acelitedvm_mask->ispresent = (HAS_ACELITEDVM);

  reg cfg_num_queues {
    default sw = rw;
    default hw = r;
    field {
      desc = "Number of queues each port can reach. We modulu the result of the xor-masking by this value.
       This allows number of queues per port to be not a power of 2. User must assert no overflow:
       sum(cfg_num_queues_acelite) + cfg_num_queues_acelitedvm <= TOTAL_NUM_QUEUES";
    } value [LOG2_NUM_QUEUES-1:0] = 1;
  };

  reg cfg_div_num_queues {
    default sw = rw;
    default hw = r;
    field {
      desc = "k=clog2(TOTAL_NUM_QUEUES)
      floor(2**k/cfg_num_queues). Used to calculate the modulu
       This allows number of queues per port to be not a power of 2.
       res = x%cfg_num_queues ->
       1. pre_res = x-(cfg_div_num_queeus*x)>>k * cfg_num_queues
       2. res = (pre_res >= cfg_num_queues) ? pre_res - cfg_num_queues : pre_res";
    } value [HASH_MASK_REDUCED_WIDTH:0] = (1<<HASH_MASK_REDUCED_WIDTH);
  };

  cfg_num_queues cfg_acelite_num_queues[NUM_ACELITE_FIXED];
  cfg_num_queues cfg_acelitedvm_num_queues;
  cfg_div_num_queues cfg_acelite_div_num_queues[NUM_ACELITE_FIXED];
  cfg_div_num_queues cfg_acelitedvm_div_num_queues;

  cfg_acelite_num_queues->ispresent         = (NUM_ACELITE>0);
  cfg_acelitedvm_num_queues->ispresent      = (HAS_ACELITEDVM);
  cfg_acelite_div_num_queues->ispresent     = (NUM_ACELITE>0);
  cfg_acelitedvm_div_num_queues->ispresent  = (HAS_ACELITEDVM);

  reg {
    default sw = r;
    default hw = w;
    field {
      desc = "Indicates that the summation of num_queues_acelite +
      num_queues_acelitedvm exceeds configured TOTAL_NUM_QUEUES";
    } overflow;
  } sts_cfg_err;

};
`endif
