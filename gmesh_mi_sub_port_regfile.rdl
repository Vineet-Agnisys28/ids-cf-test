`include "idsProperty2a.rdl"

`ifndef _GMESH_MI_SUB_PORT_REGFILE_
`define _GMESH_MI_SUB_PORT_REGFILE_

 regfile gmesh_mi_sub_port_regfile #(
   longint unsigned WEIGHT_WIDTH      = 8

 ){
   name = "gmesh_mi_sub_port_regfile";
   desc = "Gmesh MI-Sub Port CSR Register File";

   default sw = rw;
   default hw = r;


  //========================
  //  Arbitration Weights
  //==========================


  reg {
    desc = "TX Response channel arbiter weights";
    field {desc  = "Down Stream TX Response arbiter weight";} ds[WEIGHT_WIDTH-1:0]     = {WEIGHT_WIDTH{1'b1}};
    field {desc  = "Up Stream TX Response arbiter weight";}   us[WEIGHT_WIDTH-1+8:8]   = {WEIGHT_WIDTH{1'b1}};
    field {desc  = "DVM-H/B TX Response arbiter weight";}     dvm[WEIGHT_WIDTH-1+16:16]= {WEIGHT_WIDTH{1'b1}};
  } cfg_tx_rsp_arb_weights;

  reg {
    desc = "TX DAT channel arbiter weights";
    field {desc  = "Down Stream TX DAT arbiter weight";} ds[WEIGHT_WIDTH-1:0]     = {WEIGHT_WIDTH{1'b1}};
    field {desc  = "Up Stream TX DAT arbiter weight";}   us[WEIGHT_WIDTH-1+8:8]   = {WEIGHT_WIDTH{1'b1}};
    field {desc  = "DVM-H TX DAT arbiter weight";}       dvm[WEIGHT_WIDTH-1+16:16]= {WEIGHT_WIDTH{1'b1}};
  } cfg_tx_dat_arb_weights;


  reg {
    desc = "TX CRD channel arbiter weights";
    field {desc  = "Down Stream TX CRD arbiter weight";} ds[WEIGHT_WIDTH-1:0]     = {WEIGHT_WIDTH{1'b1}};
    field {desc  = "DVM-H TX CRD arbiter weight";}       dvm[WEIGHT_WIDTH-1+16:16]= {WEIGHT_WIDTH{1'b1}};
  } cfg_tx_crd_arb_weights;

};

`endif
